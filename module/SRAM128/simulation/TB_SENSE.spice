** sch_path: ../schematic/TB_SENSE.sch
**.subckt TB_SENSE CE WRn WRp DIN VSS VDD A1n,A1p A4p,A4n A0p,A0n A2p,A2n A3p,A3n CLK WR
*.ipin CE
*.ipin WRn
*.ipin WRp
*.ipin DIN
*.iopin VSS
*.iopin VDD
*.ipin A1n,A1p
*.ipin A4p,A4n
*.ipin A0p,A0n
*.ipin A2p,A2n
*.ipin A3p,A3n
*.ipin CLK
*.ipin WR
xWDRV VDD WRn BLp BLn WRp VSS DIN WDRV
xSA VDD PRn net1 BLp BLn LATp VSS SA
xCELL[0] VDD WL[0] BLn BLp VSS BIT_CELL
xCELL[1] VDD WL[1] BLn BLp VSS BIT_CELL
xCELL[2] VDD WL[2] BLn BLp VSS BIT_CELL
xCELL[3] VDD WL[3] BLn BLp VSS BIT_CELL
xCELL[4] VDD WL[4] BLn BLp VSS BIT_CELL
xCELL[5] VDD WL[5] BLn BLp VSS BIT_CELL
xCELL[6] VDD WL[6] BLn BLp VSS BIT_CELL
xCELL[7] VDD WL[7] BLn BLp VSS BIT_CELL
xCELL[8] VDD WL[8] BLn BLp VSS BIT_CELL
xCELL[9] VDD WL[9] BLn BLp VSS BIT_CELL
xCELL[10] VDD WL[10] BLn BLp VSS BIT_CELL
xCELL[11] VDD WL[11] BLn BLp VSS BIT_CELL
xCELL[12] VDD WL[12] BLn BLp VSS BIT_CELL
xCELL[13] VDD WL[13] BLn BLp VSS BIT_CELL
xCELL[14] VDD WL[14] BLn BLp VSS BIT_CELL
xCELL[15] VDD WL[15] BLn BLp VSS BIT_CELL
xCELL[16] VDD WL[16] BLn BLp VSS BIT_CELL
xCELL[17] VDD WL[17] BLn BLp VSS BIT_CELL
xCELL[18] VDD WL[18] BLn BLp VSS BIT_CELL
xCELL[19] VDD WL[19] BLn BLp VSS BIT_CELL
xCELL[20] VDD WL[20] BLn BLp VSS BIT_CELL
xCELL[21] VDD WL[21] BLn BLp VSS BIT_CELL
xCELL[22] VDD WL[22] BLn BLp VSS BIT_CELL
xCELL[23] VDD WL[23] BLn BLp VSS BIT_CELL
xCELL[24] VDD WL[24] BLn BLp VSS BIT_CELL
xCELL[25] VDD WL[25] BLn BLp VSS BIT_CELL
xCELL[26] VDD WL[26] BLn BLp VSS BIT_CELL
xCELL[27] VDD WL[27] BLn BLp VSS BIT_CELL
xCELL[28] VDD WL[28] BLn BLp VSS BIT_CELL
xCELL[29] VDD WL[29] BLn BLp VSS BIT_CELL
xCELL[30] VDD WL[30] BLn BLp VSS BIT_CELL
xCELL[31] VDD WL[31] BLn BLp VSS BIT_CELL
xDEC[0] VDD PR0 WL[0] A2n A1n A0n VSS DEC
xDEC[1] VDD PR0 WL[1] A2n A1n A0p VSS DEC
xDEC[2] VDD PR0 WL[2] A2n A1p A0n VSS DEC
xDEC[3] VDD PR0 WL[3] A2n A1p A0p VSS DEC
xDEC[4] VDD PR0 WL[4] A2p A1n A0n VSS DEC
xDEC[5] VDD PR0 WL[5] A2p A1n A0p VSS DEC
xDEC[6] VDD PR0 WL[6] A2p A1p A0n VSS DEC
xDEC[7] VDD PR0 WL[7] A2p A1p A0p VSS DEC
xDEC[8] VDD PR1 WL[8] A2n A1n A0n VSS DEC
xDEC[9] VDD PR1 WL[9] A2n A1n A0p VSS DEC
xDEC[10] VDD PR1 WL[10] A2n A1p A0n VSS DEC
xDEC[11] VDD PR1 WL[11] A2n A1p A0p VSS DEC
xDEC[12] VDD PR1 WL[12] A2p A1n A0n VSS DEC
xDEC[13] VDD PR1 WL[13] A2p A1n A0p VSS DEC
xDEC[14] VDD PR1 WL[14] A2p A1p A0n VSS DEC
xDEC[15] VDD PR1 WL[15] A2p A1p A0p VSS DEC
xDEC[16] VDD PR2 WL[16] A2n A1n A0n VSS DEC
xDEC[17] VDD PR2 WL[17] A2n A1n A0p VSS DEC
xDEC[18] VDD PR2 WL[18] A2n A1p A0n VSS DEC
xDEC[19] VDD PR2 WL[19] A2n A1p A0p VSS DEC
xDEC[20] VDD PR2 WL[20] A2p A1n A0n VSS DEC
xDEC[21] VDD PR2 WL[21] A2p A1n A0p VSS DEC
xDEC[22] VDD PR2 WL[22] A2p A1p A0n VSS DEC
xDEC[23] VDD PR2 WL[23] A2p A1p A0p VSS DEC
xDEC[24] VDD PR3 WL[24] A2n A1n A0n VSS DEC
xDEC[25] VDD PR3 WL[25] A2n A1n A0p VSS DEC
xDEC[26] VDD PR3 WL[26] A2n A1p A0n VSS DEC
xDEC[27] VDD PR3 WL[27] A2n A1p A0p VSS DEC
xDEC[28] VDD PR3 WL[28] A2p A1n A0n VSS DEC
xDEC[29] VDD PR3 WL[29] A2p A1n A0p VSS DEC
xDEC[30] VDD PR3 WL[30] A2p A1p A0n VSS DEC
xDEC[31] VDD PR3 WL[31] A2p A1p A0p VSS DEC
xPDEC[0] VDD CLK PR0 A4n A3n CE VSS PDEC
xPDEC[1] VDD CLK PR1 A4n A3p CE VSS PDEC
xPDEC[2] VDD CLK PR2 A4p A3n CE VSS PDEC
xPDEC[3] VDD CLK PR3 A4p A3p CE VSS PDEC
xCTL CLK PRn CE WR VDD VSS LATp SACTR
**.ends

* expanding   symbol:  WDRV.sym # of pins=7
** sym_path: ../schematic/WDRV.sym
** sch_path: ../schematic/WDRV.sch
.subckt WDRV VDD WRn BLp BLn WRp VSS DIN
*.iopin BLp
*.iopin BLn
*.ipin DIN
*.ipin WRn
*.ipin WRp
*.iopin VDD
*.iopin VSS
XXM1 BLp WRp net2 VSS NMOS w=3.4u l=1u nrd=0 nrs=0
XXM2 net2 net3 VSS VSS NMOS w=3.4u l=1u nrd=0 nrs=0
XXM3 net1 net3 VDD VDD PMOS w=3.4u l=1u nrd=0 nrs=0
XXM4 BLp WRn net1 VDD PMOS w=3.4u l=1u nrd=0 nrs=0
XXM5 net3 net4 VDD VDD PMOS w=3.4u l=1u nrd=0 nrs=0
XXM6 net3 net4 VSS VSS NMOS w=3.4u l=1u nrd=0 nrs=0
XXM7 BLn WRp net6 VSS NMOS w=3.4u l=1u nrd=0 nrs=0
XXM8 net6 net4 VSS VSS NMOS w=3.4u l=1u nrd=0 nrs=0
XXM9 net5 net4 VDD VDD PMOS w=3.4u l=1u nrd=0 nrs=0
XXM10 BLn WRn net5 VDD PMOS w=3.4u l=1u nrd=0 nrs=0
XXM11 net4 DIN VDD VDD PMOS w=3.4u l=1u nrd=0 nrs=0
XXM12 net4 DIN VSS VSS NMOS w=3.4u l=1u nrd=0 nrs=0
.ends

* expanding   symbol:  SA.sym # of pins=7
** sym_path: ../schematic/SA.sym
** sch_path: ../schematic/SA.sch
.subckt SA VDD PRn DO BLp BLn LATp VSS
*.iopin BLp
*.iopin BLn
*.ipin LATp
*.iopin VDD
*.iopin VSS
*.iopin DO
*.ipin PRn
XXM1 SENp BLn net3 VSS NMOS w=5.4u l=1u nrd=0 nrs=0
XXM2 net1 SENp net2 VSS NMOS w=5.4u l=1u nrd=0 nrs=0
XXM3 SENn LATp VDD VDD PMOS w=6.8u l=1u nrd=0 nrs=0
XXM4 DO SENn VDD VDD PMOS w=10.8u l=1u nrd=0 nrs=0
XXM5 SENn SENp VDD VDD PMOS w=6.8u l=1u nrd=0 nrs=0
XXM6 net2 LATp VSS VSS NMOS w=10.8u l=1u nrd=0 nrs=0
XXM7 SENn BLp net1 VSS NMOS w=5.4u l=1u nrd=0 nrs=0
XXM8 net3 SENn net2 VSS NMOS w=5.4u l=1u nrd=0 nrs=0
XXM9 SENp LATp VDD VDD PMOS w=6.8u l=1u nrd=0 nrs=0
XXM11 SENp SENn VDD VDD PMOS w=6.8u l=1u nrd=0 nrs=0
XXM12 DO SENn VSS VSS NMOS w=6.8u l=1u nrd=0 nrs=0
XXM10 net4 SENp VDD VDD PMOS w=10.8u l=1u nrd=0 nrs=0
XXM13 net4 SENp VSS VSS NMOS w=6.8u l=1u nrd=0 nrs=0
XXM14 BLn PRn VDD VDD PMOS w=3.4u l=1.6u nrd=0 nrs=0
XXM15 BLp PRn VDD VDD PMOS w=3.4u l=1.6u nrd=0 nrs=0
XXM16 SENn SENp net2 VSS NMOS w=3.4u l=1u nrd=0 nrs=0
XXM17 SENp SENn net2 VSS NMOS w=3.4u l=1u nrd=0 nrs=0
.ends

* expanding   symbol:  BIT_CELL.sym # of pins=5
** sym_path: ../schematic/BIT_CELL.sym
** sch_path: ../schematic/BIT_CELL.sch
.subckt BIT_CELL VDD WL BLn BLp VSS
*.iopin VDD
*.iopin VSS
*.ipin WL
*.iopin BLp
*.iopin BLn
XXM1 net2 net1 VSS VSS NMOS w=3.4u l=1u nrd=0 nrs=0
XXM2 net1 net2 VSS VSS NMOS w=3.4u l=1u nrd=0 nrs=0
XXM3 net2 net1 VDD VDD PMOS w=3.4u l=1u nrd=0 nrs=0
XXM4 net1 net2 VDD VDD PMOS w=3.4u l=1u nrd=0 nrs=0
XXM5 BLp WL net2 VSS NMOS w=3.4u l=1u nrd=0 nrs=0
XXM6 BLn WL net1 VSS NMOS w=3.4u l=1u nrd=0 nrs=0
.ends

* expanding   symbol:  DEC.sym # of pins=7
** sym_path: ../schematic/DEC.sym
** sch_path: ../schematic/DEC.sch
.subckt DEC VDD PRn WL A2x A1x A0x VSS
*.opin WL
*.ipin PRn
*.ipin A2x
*.ipin A1x
*.ipin A0x
*.iopin VDD
*.iopin VSS
XXM1 WL net1 VDD VDD PMOS w=13.6u l=1u nrd=0 nrs=0
XXM2 net1 A2x net2 VSS NMOS w=3.4u l=1u nrd=0 nrs=0
XXM3 net1 PRn VDD VDD PMOS w=3.4u l=1u nrd=0 nrs=0
XXM4 WL net1 VSS VSS NMOS w=13.6u l=1u nrd=0 nrs=0
XXM5 net2 A1x net3 VSS NMOS w=3.4u l=1u nrd=0 nrs=0
XXM6 net3 A0x net4 VSS NMOS w=3.4u l=1u nrd=0 nrs=0
XXM7 net4 PRn VSS VSS NMOS w=3.4u l=1u nrd=0 nrs=0
.ends

* expanding   symbol:  PDEC.sym # of pins=7
** sym_path: ../schematic/PDEC.sym
** sch_path: ../schematic/PDEC.sch
.subckt PDEC VDD CLK PRx A4x A3x CE VSS
*.opin PRx
*.ipin CLK
*.ipin A4x
*.ipin A3x
*.ipin CE
*.iopin VDD
*.iopin VSS
XXM1 PRx net1 VDD VDD PMOS w=6.8u l=1u nrd=0 nrs=0
XXM2 net1 A4x net2 VSS NMOS w=3.4u l=1u nrd=0 nrs=0
XXM3 net1 CLK VDD VDD PMOS w=3.4u l=1u nrd=0 nrs=0
XXM4 PRx net1 VSS VSS NMOS w=6.8u l=1u nrd=0 nrs=0
XXM5 net2 A3x net3 VSS NMOS w=3.4u l=1u nrd=0 nrs=0
XXM6 net3 CE net4 VSS NMOS w=3.4u l=1u nrd=0 nrs=0
XXM7 net4 CLK VSS VSS NMOS w=3.4u l=1u nrd=0 nrs=0
.ends

* expanding   symbol:  SACTR.sym # of pins=7
** sym_path: ../schematic/SACTR.sym
** sch_path: ../schematic/SACTR.sch
.subckt SACTR CLK PRn CE WR VDD VSS LATp
*.opin PRn
*.ipin CLK
*.ipin CE
*.iopin VDD
*.iopin VSS
*.opin LATp
*.ipin WR
XXM2 net1 CE net4 VSS NMOS w=3.4u l=1u nrd=0 nrs=0
XXM3 net1 CLK VDD VDD PMOS w=3.4u l=1u nrd=0 nrs=0
XXM5 VDD net6 LATp VSS NMOS w=6.8u l=1u nrd=0 nrs=0
XXM7 net4 CLK VSS VSS NMOS w=3.4u l=1u nrd=0 nrs=0
XXM6 PRn net1 net3 VSS NMOS w=6.8u l=1u nrd=0 nrs=0
XXM8 PRn net1 VDD VDD PMOS w=6.8u l=1u nrd=0 nrs=0
XXM10 net3 net2 VSS VSS NMOS w=6.8u l=1u nrd=0 nrs=0
XXM11 PRn net2 VDD VDD PMOS w=6.8u l=1u nrd=0 nrs=0
XXM9 net2 PR_DLY VDD VDD PMOS w=3.4u l=2u nrd=0 nrs=0
XXM12 net2 PR_DLY VSS VSS NMOS w=3.4u l=2u nrd=0 nrs=0
XXM13 PR_DLY net1 VDD VDD PMOS w=3.4u l=1u nrd=0 nrs=0
XXM14 PR_DLY net1 VSS VSS NMOS w=3.4u l=3u nrd=0 nrs=0
XXM15 VDD PR_DLY VDD VDD PMOS w=3.4u l=3u nrd=0 nrs=0
XXM1 LATp net6 net7 VSS NMOS w=6.8u l=1u nrd=0 nrs=0
XXM4 LATp PRn VDD VDD PMOS w=6.8u l=1u nrd=0 nrs=0
XXM16 net7 PRn VSS VSS NMOS w=6.8u l=1u nrd=0 nrs=0
XXM21 net5 LAT_DLY VDD VDD PMOS w=3.4u l=2u nrd=0 nrs=0
XXM22 net5 LAT_DLY VSS VSS NMOS w=3.4u l=2u nrd=0 nrs=0
XXM23 LAT_DLY PRn VDD VDD PMOS w=3.4u l=1u nrd=0 nrs=0
XXM24 LAT_DLY PRn VSS VSS NMOS w=3.4u l=3u nrd=0 nrs=0
XXM25 VDD LAT_DLY VDD VDD PMOS w=3.4u l=3u nrd=0 nrs=0
XXM27 net6 net5 net8 VDD PMOS w=3.4u l=1u nrd=0 nrs=0
XXM28 net6 net5 VSS VSS NMOS w=3.4u l=1u nrd=0 nrs=0
XXM17 net8 WR VDD VDD PMOS w=3.4u l=1u nrd=0 nrs=0
XXM18 net6 WR VSS VSS NMOS w=3.4u l=1u nrd=0 nrs=0
.ends

.end
