** sch_path: ../schematic/SRAM_32x4.sch
.subckt SRAM_32x4 PR0 PR1 A0p A1p A2p A3p A0n A1n A2n A3n BLp[0] BLp[1] BLp[2] BLp[3] BLn[0] BLn[1] BLn[2] BLn[3] VDD VSS
*.PININFO PR0,PR1:I BLn[0:3]:B BLp[0:3]:B A0n,A1n,A2n,A3n:I A0p,A1p,A2p,A3p:I VSS:B VDD:B
xCELL[0] WL[0] WL[1] WL[2] WL[3] WL[4] WL[5] WL[6] WL[7] WL[8] WL[9] WL[10] WL[11] WL[12] WL[13] WL[14] WL[15] WL[16] WL[17]
+ WL[18] WL[19] WL[20] WL[21] WL[22] WL[23] WL[24] WL[25] WL[26] WL[27] WL[28] WL[29] WL[30] WL[31] BLp[0] BLn[0] VDD VSS BIT_CELL32
xCELL[1] WL[0] WL[1] WL[2] WL[3] WL[4] WL[5] WL[6] WL[7] WL[8] WL[9] WL[10] WL[11] WL[12] WL[13] WL[14] WL[15] WL[16] WL[17]
+ WL[18] WL[19] WL[20] WL[21] WL[22] WL[23] WL[24] WL[25] WL[26] WL[27] WL[28] WL[29] WL[30] WL[31] BLp[1] BLn[1] VDD VSS BIT_CELL32
xCELL[2] WL[0] WL[1] WL[2] WL[3] WL[4] WL[5] WL[6] WL[7] WL[8] WL[9] WL[10] WL[11] WL[12] WL[13] WL[14] WL[15] WL[16] WL[17]
+ WL[18] WL[19] WL[20] WL[21] WL[22] WL[23] WL[24] WL[25] WL[26] WL[27] WL[28] WL[29] WL[30] WL[31] BLp[2] BLn[2] VDD VSS BIT_CELL32
xCELL[3] WL[0] WL[1] WL[2] WL[3] WL[4] WL[5] WL[6] WL[7] WL[8] WL[9] WL[10] WL[11] WL[12] WL[13] WL[14] WL[15] WL[16] WL[17]
+ WL[18] WL[19] WL[20] WL[21] WL[22] WL[23] WL[24] WL[25] WL[26] WL[27] WL[28] WL[29] WL[30] WL[31] BLp[3] BLn[3] VDD VSS BIT_CELL32
xDEC[0] VDD PR0 WL[0] A2n A1n A0n VSS A3n DEC
xDEC[1] VDD PR0 WL[1] A2n A1n A0p VSS A3n DEC
xDEC[2] VDD PR0 WL[2] A2n A1p A0n VSS A3n DEC
xDEC[3] VDD PR0 WL[3] A2n A1p A0p VSS A3n DEC
xDEC[4] VDD PR0 WL[4] A2p A1n A0n VSS A3n DEC
xDEC[5] VDD PR0 WL[5] A2p A1n A0p VSS A3n DEC
xDEC[6] VDD PR0 WL[6] A2p A1p A0n VSS A3n DEC
xDEC[7] VDD PR0 WL[7] A2p A1p A0p VSS A3n DEC
xDEC[8] VDD PR0 WL[8] A2n A1n A0n VSS A3p DEC
xDEC[9] VDD PR0 WL[9] A2n A1n A0p VSS A3p DEC
xDEC[10] VDD PR0 WL[10] A2n A1p A0n VSS A3p DEC
xDEC[11] VDD PR0 WL[11] A2n A1p A0p VSS A3p DEC
xDEC[12] VDD PR0 WL[12] A2p A1n A0n VSS A3p DEC
xDEC[13] VDD PR0 WL[13] A2p A1n A0p VSS A3p DEC
xDEC[14] VDD PR0 WL[14] A2p A1p A0n VSS A3p DEC
xDEC[15] VDD PR0 WL[15] A2p A1p A0p VSS A3p DEC
xDEC[16] VDD PR1 WL[16] A2n A1n A0n VSS A3n DEC
xDEC[17] VDD PR1 WL[17] A2n A1n A0p VSS A3n DEC
xDEC[18] VDD PR1 WL[18] A2n A1p A0n VSS A3n DEC
xDEC[19] VDD PR1 WL[19] A2n A1p A0p VSS A3n DEC
xDEC[20] VDD PR1 WL[20] A2p A1n A0n VSS A3n DEC
xDEC[21] VDD PR1 WL[21] A2p A1n A0p VSS A3n DEC
xDEC[22] VDD PR1 WL[22] A2p A1p A0n VSS A3n DEC
xDEC[23] VDD PR1 WL[23] A2p A1p A0p VSS A3n DEC
xDEC[24] VDD PR1 WL[24] A2n A1n A0n VSS A3p DEC
xDEC[25] VDD PR1 WL[25] A2n A1n A0p VSS A3p DEC
xDEC[26] VDD PR1 WL[26] A2n A1p A0n VSS A3p DEC
xDEC[27] VDD PR1 WL[27] A2n A1p A0p VSS A3p DEC
xDEC[28] VDD PR1 WL[28] A2p A1n A0n VSS A3p DEC
xDEC[29] VDD PR1 WL[29] A2p A1n A0p VSS A3p DEC
xDEC[30] VDD PR1 WL[30] A2p A1p A0n VSS A3p DEC
xDEC[31] VDD PR1 WL[31] A2p A1p A0p VSS A3p DEC
.ends

* expanding   symbol:  BIT_CELL32.sym # of pins=5
** sym_path: ../schematic/BIT_CELL32.sym
** sch_path: ../schematic/BIT_CELL32.sch
.subckt BIT_CELL32 WL[0] WL[1] WL[2] WL[3] WL[4] WL[5] WL[6] WL[7] WL[8] WL[9] WL[10] WL[11] WL[12] WL[13] WL[14] WL[15] WL[16]
+ WL[17] WL[18] WL[19] WL[20] WL[21] WL[22] WL[23] WL[24] WL[25] WL[26] WL[27] WL[28] WL[29] WL[30] WL[31] BLp BLn VDD VSS
*.PININFO WL[0:31]:I VSS:B VDD:B BLn:B BLp:B
xCELL[0] VDD WL[0] BLn BLp VSS BIT_CELL
xCELL[1] VDD WL[1] BLn BLp VSS BIT_CELL
xCELL[2] VDD WL[2] BLn BLp VSS BIT_CELL
xCELL[3] VDD WL[3] BLn BLp VSS BIT_CELL
xCELL[4] VDD WL[4] BLn BLp VSS BIT_CELL
xCELL[5] VDD WL[5] BLn BLp VSS BIT_CELL
xCELL[6] VDD WL[6] BLn BLp VSS BIT_CELL
xCELL[7] VDD WL[7] BLn BLp VSS BIT_CELL
xCELL[8] VDD WL[8] BLn BLp VSS BIT_CELL
xCELL[9] VDD WL[9] BLn BLp VSS BIT_CELL
xCELL[10] VDD WL[10] BLn BLp VSS BIT_CELL
xCELL[11] VDD WL[11] BLn BLp VSS BIT_CELL
xCELL[12] VDD WL[12] BLn BLp VSS BIT_CELL
xCELL[13] VDD WL[13] BLn BLp VSS BIT_CELL
xCELL[14] VDD WL[14] BLn BLp VSS BIT_CELL
xCELL[15] VDD WL[15] BLn BLp VSS BIT_CELL
xCELL[16] VDD WL[16] BLn BLp VSS BIT_CELL
xCELL[17] VDD WL[17] BLn BLp VSS BIT_CELL
xCELL[18] VDD WL[18] BLn BLp VSS BIT_CELL
xCELL[19] VDD WL[19] BLn BLp VSS BIT_CELL
xCELL[20] VDD WL[20] BLn BLp VSS BIT_CELL
xCELL[21] VDD WL[21] BLn BLp VSS BIT_CELL
xCELL[22] VDD WL[22] BLn BLp VSS BIT_CELL
xCELL[23] VDD WL[23] BLn BLp VSS BIT_CELL
xCELL[24] VDD WL[24] BLn BLp VSS BIT_CELL
xCELL[25] VDD WL[25] BLn BLp VSS BIT_CELL
xCELL[26] VDD WL[26] BLn BLp VSS BIT_CELL
xCELL[27] VDD WL[27] BLn BLp VSS BIT_CELL
xCELL[28] VDD WL[28] BLn BLp VSS BIT_CELL
xCELL[29] VDD WL[29] BLn BLp VSS BIT_CELL
xCELL[30] VDD WL[30] BLn BLp VSS BIT_CELL
xCELL[31] VDD WL[31] BLn BLp VSS BIT_CELL
.ends

* expanding   symbol:  DEC.sym # of pins=8
** sym_path: ../schematic/DEC.sym
** sch_path: ../schematic/DEC.sch
.subckt DEC VDD PRx WL A2x A1x A0x VSS A3x
*.PININFO WL:O PRx:I A2x:I A1x:I A0x:I VDD:B VSS:B A3x:I
MXM1 WL net1 VDD VDD PMOS w=13.6u l=1u
MXM2 net2 A2x net3 VSS NMOS w=3.4u l=1u
MXM3 net1 PRx VDD VDD PMOS w=3.4u l=1u
MXM4 WL net1 VSS VSS NMOS w=13.6u l=1u
MXM5 net3 A1x net4 VSS NMOS w=3.4u l=1u
MXM6 net4 A0x net5 VSS NMOS w=3.4u l=1u
MXM7 net5 PRx VSS VSS NMOS w=3.4u l=1u
MXM9 net1 A3x net2 VSS NMOS w=3.4u l=1u
.ends

* expanding   symbol:  BIT_CELL.sym # of pins=5
** sym_path: ../schematic/BIT_CELL.sym
** sch_path: ../schematic/BIT_CELL.sch
.subckt BIT_CELL VDD WL BLn BLp VSS
*.PININFO VDD:B VSS:B WL:I BLp:B BLn:B
MXM1 net2 net1 VSS VSS NMOS w=3.4u l=1u
MXM2 net1 net2 VSS VSS NMOS w=3.4u l=1u
MXM3 net2 net1 VDD VDD PMOS w=3.4u l=1u
MXM4 net1 net2 VDD VDD PMOS w=3.4u l=1u
MXM5 BLp WL net2 VSS NMOS w=3.4u l=1u
MXM6 BLn WL net1 VSS NMOS w=3.4u l=1u
.ends
