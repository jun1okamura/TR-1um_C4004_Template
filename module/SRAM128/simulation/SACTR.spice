** sch_path: /Users/okamura/Dropbox/98_LSI_Design/TR-1um_C4004/schematic/SACTR.sch
.subckt SACTR PRn CE WR VDD VSS LATp
*.PININFO PRn:O CE:I VDD:B VSS:B LATp:O WR:I
MXM3 net1 CE VDD VDD PMOS w=3.4u l=1u
MXM7 net1 CE VSS VSS NMOS w=3.4u l=1u
MXM6 PRn net1 net3 VSS NMOS w=6.8u l=1u
MXM8 PRn net1 VDD VDD PMOS w=6.8u l=1u
MXM10 net3 net2 VSS VSS NMOS w=6.8u l=1u
MXM11 PRn net2 VDD VDD PMOS w=6.8u l=1u
MXM9 net2 PR_DLY VDD VDD PMOS w=3.4u l=2u
MXM12 net2 PR_DLY VSS VSS NMOS w=3.4u l=2u
MXM13 PR_DLY net1 VDD VDD PMOS w=3.4u l=1u
MXM14 PR_DLY net1 VSS VSS NMOS w=3.4u l=10u
MXM15 VDD PR_DLY VDD VDD PMOS w=5u l=5u
MXM1 LATp net5 net6 VSS NMOS w=6.8u l=1u
MXM4 LATp PRn VDD VDD PMOS w=6.8u l=1u
MXM16 net6 PRn VSS VSS NMOS w=6.8u l=1u
MXM21 net4 LAT_DLY VDD VDD PMOS w=3.4u l=2u
MXM22 net4 LAT_DLY VSS VSS NMOS w=3.4u l=2u
MXM23 LAT_DLY PRn VDD VDD PMOS w=3.4u l=1u
MXM24 LAT_DLY PRn VSS VSS NMOS w=3.4u l=10u
MXM25 VDD LAT_DLY VDD VDD PMOS w=10u l=10u
MXM27 net5 net4 net7 VDD PMOS w=3.4u l=1u
MXM28 net5 net4 VSS VSS NMOS w=3.4u l=1u
MXM17 net7 WR VDD VDD PMOS w=3.4u l=1u
MXM18 net5 WR VSS VSS NMOS w=3.4u l=1u
MXM5 LATp net5 VDD VDD PMOS w=6.8u l=1u
.ends
