* OAI21 — LVS ソースネットリスト（Y = !((A1+A2)*B)）。2026-11-03 Claude 作成（レイアウト抽出から）。
*   PMOS: (A1 と A2 の直列) || B、NMOS: B と (A1 || A2) の直列。check_comb 8/8。
*
.subckt OAI21 A1 A2 B Y vdd vss
MP0 n8 A1 vdd vdd PMOS W=10.2u L=1u
MP1 Y A2 n8 vdd PMOS W=10.2u L=1u
MP2 vdd B Y vdd PMOS W=10.2u L=1u
MN0 Y B n4 vss NMOS W=3.4u L=1u
MN1 n4 A1 vss vss NMOS W=3.4u L=1u
MN2 vss A2 n4 vss NMOS W=3.4u L=1u
.ends OAI21
