* OAI22 — LVS ソースネットリスト（Y = !((A1+A2)*(B1+B2))）。2026-11-03 Claude 作成（レイアウト抽出から）。
*   PMOS: (A1 と A2 の直列) || (B1 と B2 の直列)、NMOS: (A1 || A2) と (B1 || B2) の直列。
*
.subckt OAI22 A1 A2 B1 B2 Y vdd vss
MP0 n10 A1 vdd vdd PMOS W=10.2u L=1u
MP1 Y A2 n10 vdd PMOS W=10.2u L=1u
MP2 n9 B1 Y vdd PMOS W=10.2u L=1u
MP3 vdd B2 n9 vdd PMOS W=10.2u L=1u
MN0 Y B1 n5 vss NMOS W=3.4u L=1u
MN1 n5 B2 Y vss NMOS W=3.4u L=1u
MN2 n5 A1 vss vss NMOS W=3.4u L=1u
MN3 vss A2 n5 vss NMOS W=3.4u L=1u
.ends OAI22
